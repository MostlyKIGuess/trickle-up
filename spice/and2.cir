* Example netlist: and2 at the nominal corner with every input at 0 V.
* scripts/06_gates_spice.py writes one deck like this per simulation, with the corner's
* process values in the model cards, its VDD and temperature, and each input at 0 or VDD.
* The model cards are given/models/22nm_LP.pm with rgatemod = 0 (see README).
* and2 inputs 00
* PTM Low Power 22nm Metal Gate / High-K / Strained-Si
* nominal Vdd = 0.95V

.model  nmos  nmos  level = 54

+version = 4.0             binunit = 1               paramchk= 1               mobmod  = 0
+capmod  = 2               igcmod  = 1               igbmod  = 1               geomod  = 1
+diomod  = 1               rdsmod  = 0               rbodymod= 1               rgatemod= 0
+permod  = 1               acnqsmod= 0               trnqsmod= 0

+tnom    = 27              toxe    = 1.4000000000e-09        toxp    = 1.1e-009        toxm    = 1.4e-009
+dtox    = 3e-010          epsrox  = 3.9             wint    = 5e-009          lint    = 0
+ll      = 0               wl      = 0               lln     = 1               wln     = 1
+lw      = 0               ww      = 0               lwn     = 1               wwn     = 1
+lwl     = 0               wwl     = 0               xpart   = 0               toxref  = 1.4e-009

+vth0    = 6.8858000000e-01         k1      = 0.4             k2      = 0               k3      = 0
+k3b     = 0               w0      = 2.5e-006        dvt0    = 1               dvt1    = 2
+dvt2    = 0               dvt0w   = 0               dvt1w   = 0               dvt2w   = 0
+dsub    = 0.1             minv    = 0.05            voffl   = 0               dvtp0   = 1e-011
+dvtp1   = 0.1             lpe0    = 0               lpeb    = 0               xj      = 7.2000000000e-09
+ngate   = 1e+023          ndep    = 5.5000000000e+18        nsd     = 2e+020          phin    = 0
+cdsc    = 0               cdscb   = 0               cdscd   = 0               cit     = 0
+voff    = -0.1092         nfactor = 1.6             eta0    = 0.0105          etab    = 0
+vfb     = -0.55           u0      = 3.5000000000e-02           ua      = 6e-010          ub      = 1.2e-018
+uc      = 0               vsat    = 170000          a0      = 1               ags     = 0
+a1      = 0               a2      = 1               b0      = 0               b1      = 0
+keta    = 0.04            dwg     = 0               dwb     = 0               pclm    = 0.02
+pdiblc1 = 0.001           pdiblc2 = 0.001           pdiblcb = -0.005          drout   = 0.5
+pvag    = 1e-020          delta   = 0.01            pscbe1  = 8.14e+008       pscbe2  = 1e-007
+fprout  = 0.2             pdits   = 0.01            pditsd  = 0.23            pditsl  = 2300000
+rsh     = 5               rdsw    = 180             rsw     = 75              rdw     = 75
+rdswmin = 0               rdwmin  = 0               rswmin  = 0               prwg    = 0
+prwb    = 0               wr      = 1               alpha0  = 0.074           alpha1  = 0.005
+beta0   = 30              agidl   = 0.0002          bgidl   = 2.1e+009        cgidl   = 0.0002
+egidl   = 0.8             aigbacc = 0.012           bigbacc = 0.0028          cigbacc = 0.002
+nigbacc = 1               aigbinv = 0.014           bigbinv = 0.004           cigbinv = 0.004
+eigbinv = 1.1             nigbinv = 3               aigc    = 0.015211        bigc    = 0.0027432
+cigc    = 0.002           aigsd   = 0.015211        bigsd   = 0.0027432       cigsd   = 0.002
+nigc    = 1               poxedge = 1               pigcd   = 1               ntox    = 1
+xrcrg1  = 12              xrcrg2  = 5

+cgso    = 6.5e-011        cgdo    = 6.5e-011        cgbo    = 2.56e-011       cgdl    = 2.653e-010
+cgsl    = 2.653e-010      ckappas = 0.03            ckappad = 0.03            acde    = 1
+moin    = 15              noff    = 0.9             voffcv  = 0.02

+kt1     = -0.11           kt1l    = 0               kt2     = 0.022           ute     = -1.5
+ua1     = 4.31e-009       ub1     = 7.61e-018       uc1     = -5.6e-011       prt     = 0
+at      = 33000

+fnoimod = 1               tnoimod = 0

+jss     = 0.0001          jsws    = 1e-011          jswgs   = 1e-010          njs     = 1
+ijthsfwd= 0.01            ijthsrev= 0.001           bvs     = 10              xjbvs   = 1
+jsd     = 0.0001          jswd    = 1e-011          jswgd   = 1e-010          njd     = 1
+ijthdfwd= 0.01            ijthdrev= 0.001           bvd     = 10              xjbvd   = 1
+pbs     = 1               cjs     = 0.0005          mjs     = 0.5             pbsws   = 1
+cjsws   = 5e-010          mjsws   = 0.33            pbswgs  = 1               cjswgs  = 3e-010
+mjswgs  = 0.33            pbd     = 1               cjd     = 0.0005          mjd     = 0.5
+pbswd   = 1               cjswd   = 5e-010          mjswd   = 0.33            pbswgd  = 1
+cjswgd  = 5e-010          mjswgd  = 0.33            tpb     = 0.005           tcj     = 0.001
+tpbsw   = 0.005           tcjsw   = 0.001           tpbswg  = 0.005           tcjswg  = 0.001
+xtis    = 3               xtid    = 3

+dmcg    = 0               dmci    = 0               dmdg    = 0               dmcgt   = 0
+dwj     = 0               xgw     = 0               xgl     = 0

+rshg    = 0.4             gbmin   = 1e-010          rbpb    = 5               rbpd    = 15
+rbps    = 15              rbdb    = 15              rbsb    = 15              ngcon   = 1

.model  pmos  pmos  level = 54

+version = 4.0             binunit = 1               paramchk= 1               mobmod  = 0
+capmod  = 2               igcmod  = 1               igbmod  = 1               geomod  = 1
+diomod  = 1               rdsmod  = 0               rbodymod= 1               rgatemod= 0
+permod  = 1               acnqsmod= 0               trnqsmod= 0

+tnom    = 27              toxe    = 1.4000000000e-09        toxp    = 1.08e-009       toxm    = 1.42e-009
+dtox    = 3.2e-010        epsrox  = 3.9             wint    = 5e-009          lint    = 0
+ll      = 0               wl      = 0               lln     = 1               wln     = 1
+lw      = 0               ww      = 0               lwn     = 1               wwn     = 1
+lwl     = 0               wwl     = 0               xpart   = 0               toxref  = 1.42e-009

+vth0    = -6.3745000000e-01        k1      = 0.4             k2      = -0.01           k3      = 0
+k3b     = 0               w0      = 2.5e-006        dvt0    = 1               dvt1    = 2
+dvt2    = -0.032          dvt0w   = 0               dvt1w   = 0               dvt2w   = 0
+dsub    = 0.1             minv    = 0.05            voffl   = 0               dvtp0   = 1e-011
+dvtp1   = 0.05            lpe0    = 0               lpeb    = 0               xj      = 7.2000000000e-09
+ngate   = 1e+023          ndep    = 4.4000000000e+18        nsd     = 2e+020          phin    = 0
+cdsc    = 0               cdscb   = 0               cdscd   = 0               cit     = 0
+voff    = -0.09           nfactor = 1.8             eta0    = 0.0105          etab    = 0
+vfb     = 0.55            u0      = 1.1000000000e-02           ua      = 2e-009          ub      = 5e-019
+uc      = 0               vsat    = 170000          a0      = 1               ags     = 1e-020
+a1      = 0               a2      = 1               b0      = 0               b1      = 0
+keta    = -0.047          dwg     = 0               dwb     = 0               pclm    = 0.12
+pdiblc1 = 0.001           pdiblc2 = 0.001           pdiblcb = 3.4e-008        drout   = 0.56
+pvag    = 1e-020          delta   = 0.01            pscbe1  = 8.14e+008       pscbe2  = 9.58e-007
+fprout  = 0.2             pdits   = 0.08            pditsd  = 0.23            pditsl  = 2300000
+rsh     = 5               rdsw    = 230             rsw     = 72.5            rdw     = 72.5
+rdswmin = 0               rdwmin  = 0               rswmin  = 0               prwg    = 0
+prwb    = 0               wr      = 1               alpha0  = 0.074           alpha1  = 0.005
+beta0   = 30              agidl   = 0.0002          bgidl   = 2.1e+009        cgidl   = 0.0002
+egidl   = 0.8             aigbacc = 0.012           bigbacc = 0.0028          cigbacc = 0.002
+nigbacc = 1               aigbinv = 0.014           bigbinv = 0.004           cigbinv = 0.004
+eigbinv = 1.1             nigbinv = 3               aigc    = 0.0097          bigc    = 0.00125
+cigc    = 0.0008          aigsd   = 0.0097          bigsd   = 0.00125         cigsd   = 0.0008
+nigc    = 1               poxedge = 1               pigcd   = 1               ntox    = 1
+xrcrg1  = 12              xrcrg2  = 5

+cgso    = 6.5e-011        cgdo    = 6.5e-011        cgbo    = 2.56e-011       cgdl    = 2.653e-010
+cgsl    = 2.653e-010      ckappas = 0.03            ckappad = 0.03            acde    = 1
+moin    = 15              noff    = 0.9             voffcv  = 0.02

+kt1     = -0.11           kt1l    = 0               kt2     = 0.022           ute     = -1.5
+ua1     = 4.31e-009       ub1     = 7.61e-018       uc1     = -5.6e-011       prt     = 0
+at      = 33000

+fnoimod = 1               tnoimod = 0

+jss     = 0.0001          jsws    = 1e-011          jswgs   = 1e-010          njs     = 1
+ijthsfwd= 0.01            ijthsrev= 0.001           bvs     = 10              xjbvs   = 1
+jsd     = 0.0001          jswd    = 1e-011          jswgd   = 1e-010          njd     = 1
+ijthdfwd= 0.01            ijthdrev= 0.001           bvd     = 10              xjbvd   = 1
+pbs     = 1               cjs     = 0.0005          mjs     = 0.5             pbsws   = 1
+cjsws   = 5e-010          mjsws   = 0.33            pbswgs  = 1               cjswgs  = 3e-010
+mjswgs  = 0.33            pbd     = 1               cjd     = 0.0005          mjd     = 0.5
+pbswd   = 1               cjswd   = 5e-010          mjswd   = 0.33            pbswgd  = 1
+cjswgd  = 5e-010          mjswgd  = 0.33            tpb     = 0.005           tcj     = 0.001
+tpbsw   = 0.005           tcjsw   = 0.001           tpbswg  = 0.005           tcjswg  = 0.001
+xtis    = 3               xtid    = 3

+dmcg    = 0               dmci    = 0               dmdg    = 0               dmcgt   = 0
+dwj     = 0               xgw     = 0               xgl     = 0

+rshg    = 0.4             gbmin   = 1e-010          rbpb    = 5               rbpd    = 15
+rbps    = 15              rbdb    = 15              rbsb    = 15              ngcon   = 1

.options gmin=1e-18 abstol=1e-18 reltol=1e-6 vntol=1e-9
.temp 27.000000

mnb inner b x 0 nmos W=4.400000e-08 L=2.200000e-08 AD=1.936000e-15 AS=1.936000e-15 PD=1.760000e-07 PS=1.760000e-07
mna x a 0 0 nmos W=4.400000e-08 L=2.200000e-08 AD=1.936000e-15 AS=1.936000e-15 PD=1.760000e-07 PS=1.760000e-07
mpa inner a vdd vdd pmos W=4.400000e-08 L=2.200000e-08 AD=1.936000e-15 AS=1.936000e-15 PD=1.760000e-07 PS=1.760000e-07
mpb inner b vdd vdd pmos W=4.400000e-08 L=2.200000e-08 AD=1.936000e-15 AS=1.936000e-15 PD=1.760000e-07 PS=1.760000e-07
mni out inner 0 0 nmos W=2.200000e-08 L=2.200000e-08 AD=9.680000e-16 AS=9.680000e-16 PD=1.320000e-07 PS=1.320000e-07
mpi out inner vdd vdd pmos W=4.400000e-08 L=2.200000e-08 AD=1.936000e-15 AS=1.936000e-15 PD=1.760000e-07 PS=1.760000e-07
v_vdd vdd 0 1.000000000
v_a a 0 0.000000000
v_b b 0 0.000000000

.control
set numdgt=12
set num_threads=1
op
let mnb_fwd = @mnb[vds] ge 0
let mnb_id = (mnb_fwd * (@mnb[id] + @mnb[isub] - @mnb[igcd]) - (1 - mnb_fwd) * (@mnb[id] + @mnb[igcs]) + @mnb[igidl] - @mnb[ibd] - @mnb[igd])
let mnb_ig = (@mnb[igs] + @mnb[igd] + @mnb[igcs] + @mnb[igcd] + @mnb[igb])
let mnb_ib = (@mnb[ibd] + @mnb[ibs] - @mnb[igidl] - @mnb[igisl] - @mnb[isub] - @mnb[igb])
let mnb_is = -(mnb_id + mnb_ig + mnb_ib)
let mna_fwd = @mna[vds] ge 0
let mna_id = (mna_fwd * (@mna[id] + @mna[isub] - @mna[igcd]) - (1 - mna_fwd) * (@mna[id] + @mna[igcs]) + @mna[igidl] - @mna[ibd] - @mna[igd])
let mna_ig = (@mna[igs] + @mna[igd] + @mna[igcs] + @mna[igcd] + @mna[igb])
let mna_ib = (@mna[ibd] + @mna[ibs] - @mna[igidl] - @mna[igisl] - @mna[isub] - @mna[igb])
let mna_is = -(mna_id + mna_ig + mna_ib)
let mpa_fwd = @mpa[vds] ge 0
let mpa_id = -(mpa_fwd * (@mpa[id] + @mpa[isub] - @mpa[igcd]) - (1 - mpa_fwd) * (@mpa[id] + @mpa[igcs]) + @mpa[igidl] - @mpa[ibd] - @mpa[igd])
let mpa_ig = -(@mpa[igs] + @mpa[igd] + @mpa[igcs] + @mpa[igcd] + @mpa[igb])
let mpa_ib = -(@mpa[ibd] + @mpa[ibs] - @mpa[igidl] - @mpa[igisl] - @mpa[isub] - @mpa[igb])
let mpa_is = -(mpa_id + mpa_ig + mpa_ib)
let mpb_fwd = @mpb[vds] ge 0
let mpb_id = -(mpb_fwd * (@mpb[id] + @mpb[isub] - @mpb[igcd]) - (1 - mpb_fwd) * (@mpb[id] + @mpb[igcs]) + @mpb[igidl] - @mpb[ibd] - @mpb[igd])
let mpb_ig = -(@mpb[igs] + @mpb[igd] + @mpb[igcs] + @mpb[igcd] + @mpb[igb])
let mpb_ib = -(@mpb[ibd] + @mpb[ibs] - @mpb[igidl] - @mpb[igisl] - @mpb[isub] - @mpb[igb])
let mpb_is = -(mpb_id + mpb_ig + mpb_ib)
let mni_fwd = @mni[vds] ge 0
let mni_id = (mni_fwd * (@mni[id] + @mni[isub] - @mni[igcd]) - (1 - mni_fwd) * (@mni[id] + @mni[igcs]) + @mni[igidl] - @mni[ibd] - @mni[igd])
let mni_ig = (@mni[igs] + @mni[igd] + @mni[igcs] + @mni[igcd] + @mni[igb])
let mni_ib = (@mni[ibd] + @mni[ibs] - @mni[igidl] - @mni[igisl] - @mni[isub] - @mni[igb])
let mni_is = -(mni_id + mni_ig + mni_ib)
let mpi_fwd = @mpi[vds] ge 0
let mpi_id = -(mpi_fwd * (@mpi[id] + @mpi[isub] - @mpi[igcd]) - (1 - mpi_fwd) * (@mpi[id] + @mpi[igcs]) + @mpi[igidl] - @mpi[ibd] - @mpi[igd])
let mpi_ig = -(@mpi[igs] + @mpi[igd] + @mpi[igcs] + @mpi[igcd] + @mpi[igb])
let mpi_ib = -(@mpi[ibd] + @mpi[ibs] - @mpi[igidl] - @mpi[igisl] - @mpi[isub] - @mpi[igb])
let mpi_is = -(mpi_id + mpi_ig + mpi_ib)
let leak_device = 0
let leak_device = leak_device + mpa_is
let leak_device = leak_device + mpa_ib
let leak_device = leak_device + mpb_is
let leak_device = leak_device + mpb_ib
let leak_device = leak_device + mpi_is
let leak_device = leak_device + mpi_ib
let leak_source = 0 - i(v_vdd)
let v_out = v(out)
let v_x = v(x)
let v_inner = v(inner)
print leak_device leak_source v_out v_x v_inner mnb_id mnb_ig mnb_is
print mnb_ib mna_id mna_ig mna_is mna_ib mpa_id mpa_ig mpa_is
print mpa_ib mpb_id mpb_ig mpb_is mpb_ib mni_id mni_ig mni_is
print mni_ib mpi_id mpi_ig mpi_is mpi_ib
.endc
.end
